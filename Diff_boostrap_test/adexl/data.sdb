ADE simulation setup
Run mode: Single Run, Sweeps and Corners
Tests:
  215d:Diff_boostrap_test:1: 215d/Diff_boostrap_test/schematic, simulator spectre
    Outputs: gate
