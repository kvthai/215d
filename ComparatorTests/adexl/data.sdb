ADE simulation setup
Run mode: Single Run, Sweeps and Corners
Tests:
  215d:ComparatorTests:1: 215d/ComparatorTests/schematic, simulator spectre
    Outputs: I5.PM0:cgg
Global variables:
  cur = 35
  fing = 30
Single Run, Sweeps and Corners options: submitpointsenabled=0
