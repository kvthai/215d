ADE simulation setup
Run mode: Single Run, Sweeps and Corners
Tests:
  f: 215d/SAR_Test_1/schematic, simulator spectre
