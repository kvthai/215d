ADE simulation setup
Run mode: Single Run, Sweeps and Corners
Tests:
  215d:SAR_Test_1:1: 215d/SAR_Test_1/schematic, simulator spectre
