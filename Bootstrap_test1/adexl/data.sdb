ADE simulation setup
Run mode: Single Run, Sweeps and Corners
Tests:
  215d:Bootstrap_test1:1: 215d/Bootstrap_test1/schematic, simulator spectre
