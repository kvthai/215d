ADE simulation setup
Run mode: Single Run, Sweeps and Corners
Tests:
  215d:Digital_logic_test:1: 215d/Digital_logic_test/schematic, simulator spectre
    Outputs: test_point
